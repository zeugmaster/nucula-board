Nucula battery sense divider startup, +R and +C tolerance
* ADC pin is ideal high impedance; sampling capacitor/leakage not included.
Vbattery n55 0 4.2
R15 n55 n56 474700
R16 n56 0 474700
C13 n56 0 1.1e-07 IC=0
.options reltol=1e-8
.tran 20u 300m uic
.end
