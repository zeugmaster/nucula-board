Nucula esp-enable passive release, +R and +C tolerance
* IC reset output is replaced by an ideal open circuit after release.
* No supervisor delay, glitch filtering, GPIO clamp or transistor model.
Vrail n2 0 3.31
R8 n2 n46 10100
C12 n46 0 1.1e-06 IC=0
.options reltol=1e-8
.tran 6e-06 0.06 uic
.end
